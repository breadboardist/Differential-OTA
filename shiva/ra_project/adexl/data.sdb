ADE simulation setup
Run mode: Monte Carlo Sampling
Tests:
  shiva:ra_project:1: shiva/ra_project/schematic, simulator spectre
Global variables:
  VDD = 1
Monte Carlo Sampling options: mcmethod=all, mcnumpoints=100
